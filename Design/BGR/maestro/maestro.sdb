ADE simulation setup
Run mode: Single Run, Sweeps and Corners
Tests:
  LDO_BGR_1_1: LDO/BGR_1/schematic, simulator spectre
    Variables: VDD = 1.8
