ADE simulation setup
Test LDO_BGR_1_1: LDO/BGR_1/schematic, simulator spectre
  Models: /data/tsmc/28HPCPMMWAVE/PDK/1.8.2.3a/9m/models/spectre/toplevel.scs[top_tt]
  Variables: VDD = 1.8
  Temperature: 27
  Analysis dc: sweep VDD start=0 stop=3 (saves the operating point)
  Signals: /net1, /gnd!, /net2, /net56, /net57, /net58, /net59, /V0/MINUS (terminal), /V0/PLUS (terminal), /I0/VDD (terminal), /I0/VSS (terminal), /I0/Vout (terminal), /I0/+ (terminal), /I0/- (terminal), /I1/gnd! (terminal), /Q0/C (terminal), /Q0/B (terminal), /Q0/E (terminal), /Q1/C (terminal), /Q1/B (terminal), /Q1/E (terminal), /R5/BULK (terminal), /R5/MINUS (terminal), /R5/PLUS (terminal), /R1/BULK (terminal), /R1/MINUS (terminal), /R1/PLUS (terminal), /R7/BULK (terminal), /R7/MINUS (terminal), /R7/PLUS (terminal), /R3/BULK (terminal), /R3/MINUS (terminal), /R3/PLUS (terminal), /M8/S (terminal), /M8/B (terminal), /M8/G (terminal), /M8/D (terminal), /M9/S (terminal), /M9/B (terminal), /M9/G (terminal), /M9/D (terminal), /M10/S (terminal), /M10/B (terminal), /M10/G (terminal), /M10/D (terminal)
Run mode: Single Run, Sweeps and Corners
